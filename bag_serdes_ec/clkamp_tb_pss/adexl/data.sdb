ADE simulation setup
Run mode: Single Run, Sweeps and Corners
Tests:
  tb_pss: bag_serdes_ec/clkamp_tb_pss/schematic, simulator spectre
Global variables:
  cload = 1f
  ibias = 1u
  vdd = 1
  vinac = 0.1
  vindc = 0.1
  nharm = 100
  tper_pss = 1n
