ADE simulation setup
Run mode: Single Run, Sweeps and Corners
Tests:
  dc: bag_serdes_testbenches_ec/gm_char_dc/schematic, simulator spectre
Global variables:
  bias = 0.5
  incm = 0.7
  indm = 0
  outcm = 0.8
  vdd = 0.9
  vb0 = 0
  vb1 = 0.9
