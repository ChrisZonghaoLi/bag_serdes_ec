ADE simulation setup
Run mode: Single Run, Sweeps and Corners
Tests:
  ac: bag_serdes_testbenches_ec/amp_char_vlsi/schematic, simulator spectre
